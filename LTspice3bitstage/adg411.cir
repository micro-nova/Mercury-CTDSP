* ADG411 SPICE Macro-model
* Generic Desc:
* Developed by: nespirit / ANALOG
* Revision History: 2 - (07/2018) (7/2018)
* Copyright 2018 by Analog Devices, Inc.
*
* Refer to http://www.analog.com/Analog_Root/static/techSupport/designTools/spiceModels/license/spice_general.html for License Statement. Use of this model
* indicates your acceptance of the terms and provisions in the License Statement.
*
* Begin Notes:
* The model will work on Vdd/Vss from 11.8V to 13.2V single supply and +/-14.5V to +/-16.5V dual supply.
* The model provides parametric specifications at +/-15V only and is not variable with Vdd and Vss changes. Please see datasheet page 3.
* The model is operational at VL level from 5V to Vdd only.
*
* Not Modeled:
*
* Please see Connections Section below.
*
* Parameters modeled include:
* On Resistance
*	Ton and Toff
*	Break-Before-Make
*	Off Isolation
*	Crosstalk
*	Supply Currents: Iss/Idd
*  Bandwidth
*  Charge Injection
* Connections
*      1  = IN1
*      2  = D1
*      3  = S1
*      4  = VSS
*      5  = GND
*      6  = S2
*      7  = D2
*      8  = IN2
*      9  = IN3
*      10  = D3
*      11  = S3
*      12  = RESET/VL
*      13  = VDD
*      14  = S4
*      15  = D4
*      16  = IN4
*
.SUBCKT ADG411 1 2 3 4 5 6 7 8 9 10 11 12 13 14 15 16

.MODEL VON VSWITCH(Von=5 Voff=0.8 Ron=0.001 Roff=111110000000)
.MODEL VEN VSWITCH(Von=5 Voff=0.8 Ron=115700 Roff=196000)
.MODEL VRESET VSWITCH(Von=5 Voff=0.8 Ron=2700000 Roff=1000)
.MODEL DCLAMP D(IS=1E-15 IBV=1E-13)

* RESET/VL
S30 12 187 12 5 VRESET
C80 187 5 5.5e-011

* CROSSTALK
C12X 3 6 150E-015
C13X 3 11 150E-015
C14X 3 14 150E-015
C23X 6 11 150E-015
C24X 6 14 150E-015
C34X 11 14 150E-015

* IDD/ISS
I1 13 5 0.001E-006
I2 4 5 0.001E-006

* Configuration: SPST 4:4

** SWITCH 1 **
*
* ESD PROTECTION DIODES
D11 4 2 DCLAMP
D12 2 13 DCLAMP
D13 4 3 DCLAMP
D14 3 13 DCLAMP
*
* OFF ISOLATION
C11 3 2 1.25E-012
*
* CHARGE INJECTION
C12 2 140 14E-012
C13 3 140 14E-012
*
* CD/CS OFF AND BANDWIDTH
C14 3 5 9E-012
C15 2 5 9E-012
*
* ON RESISTANCE
Ech155 1555 5 VALUE = { IF ((ABS(V(3)))>(ABS(V(184))),V(3),V(2)) }
R155 1555 5 1G
R11 137 2 0.001
S111 136 141 1141 5 VON
Ech111 1141 5 VALUE = { IF (V(1555)<-13,5,0) }
Ech11 141 5 VALUE = { IF (V(1555)<-13,0.142857142857143*(V(1555)--13)+15,0) }
S112 136 146 1146 5 VON
Ech112 1146 5 VALUE = { IF ((V(1555)>=-13) & (V(1555)<=14),5,0) }
Ech12 146 5 VALUE = { IF ((V(1555)>=-13) & (V(1555)<=14),((15-10)/((-13-0.855509526361275)*(-13-0.855509526361275)))*(V(1555)-0.855509526361275)*(V(1555)-0.855509526361275) + 10,0) }
S113 136 144 1144 5 VON
Ech113 1144 5 VALUE = { IF (V(1555)>14,5,0) }
Ech13 144 5 VALUE = { IF (V(1555)>14,-0.2*(V(1555)-14)+14.5,0) }
RIN1	136 5	1G
EOUT1 137 181	POLY(2) (136,5) (180,5) 0 0 0 0 0.999/1000
FCOPY1	5 180 VSENSE1 1
RSENSOR1 180 5	1K
VSENSE1 181 184	0
*
* TON/ TOFF/ BBM
S11 182 184 140 5 VON
S12 143 138 143 5 VEN
Ech14 143 5 VALUE = { IF(V(1)<=2.4 & V(187)>=4.4, 5 , 0.8 ) }
eV1 140 5 138 5 1
C16 138 5 1e-012
*
* VOLTAGE SUPPLY REQUIREMENT
S13 3 182 185 5 VON
S14 142 185 142 5 VON
Ech15 142 5 VALUE = { IF((V(4)<=-0.5 & V(4)>=-16.5) & (V(13)<=16.5 & V(13)>=14.5), 5 , 0.01 ) }
S15 139 185 139 5 VON
Ech16 139 5 VALUE = { IF((V(4)>=-0.5 & (V(13)<=13.2 & V(13)>=11.8)), 5 , 0.01 ) }

** SWITCH 2 **
*
* ESD PROTECTION DIODES
D21 4 7 DCLAMP
D22 7 13 DCLAMP
D23 4 6 DCLAMP
D24 6 13 DCLAMP
*
* OFF ISOLATION
C21 6 7 1.25E-012
*
* CHARGE INJECTION
C22 7 240 14E-012
C23 6 240 14E-012
*
* CD/CS OFF AND BANDWIDTH
C24 6 5 9E-012
C25 7 5 9E-012
*
* ON RESISTANCE
Ech255 2555 5 VALUE = { IF ((ABS(V(6)))>(ABS(V(284))),V(6),V(7)) }
R255 2555 5 1G
R21 237 7 0.001
S221 236 241 2241 5 VON
Ech221 2241 5 VALUE = { IF (V(2555)<-13,5,0) }
Ech21 241 5 VALUE = { IF (V(2555)<-13,0.142857142857143*(V(2555)--13)+15,0) }
S222 236 246 2246 5 VON
Ech222 2246 5 VALUE = { IF ((V(2555)>=-13) & (V(2555)<=14),5,0) }
Ech22 246 5 VALUE = { IF ((V(2555)>=-13) & (V(2555)<=14),((15-10)/((-13-0.855509526361275)*(-13-0.855509526361275)))*(V(2555)-0.855509526361275)*(V(2555)-0.855509526361275) + 10,0) }
S223 236 244 2244 5 VON
Ech223 2244 5 VALUE = { IF (V(2555)>14,5,0) }
Ech23 244 5 VALUE = { IF (V(2555)>14,-0.2*(V(2555)-14)+14.5,0) }
RIN2	236 5	1G
EOUT2 237 281	POLY(2) (236,5) (280,5) 0 0 0 0 0.999/1000
FCOPY2	5 280 VSENSE2 1
RSENSOR2 280 5	1K
VSENSE2 281 284	0
*
* TON/ TOFF/ BBM
S21 282 284 240 5 VON
S22 243 238 243 5 VEN
Ech24 243 5 VALUE = { IF(V(8)<=2.4 & V(187)>=4.4, 5 , 0.8 ) }
eV2 240 5 238 5 1
C26 238 5 1e-012
*
* VOLTAGE SUPPLY REQUIREMENT
S23 6 282 285 5 VON
S24 242 285 242 5 VON
Ech25 242 5 VALUE = { IF((V(4)<=-0.5 & V(4)>=-16.5) & (V(13)<=16.5 & V(13)>=14.5), 5 , 0.01 ) }
S25 239 285 239 5 VON
Ech26 239 5 VALUE = { IF((V(4)>=-0.5 & (V(13)<=13.2 & V(13)>=11.8)), 5 , 0.01 ) }

** SWITCH 3 **
*
* ESD PROTECTION DIODES
D31 4 10 DCLAMP
D32 10 13 DCLAMP
D33 4 11 DCLAMP
D34 11 13 DCLAMP
*
* OFF ISOLATION
C31 11 10 1.25E-012
*
* CHARGE INJECTION
C32 10 340 14E-012
C33 11 340 14E-012
*
* CD/CS OFF AND BANDWIDTH
C34 11 5 9E-012
C35 10 5 9E-012
*
* ON RESISTANCE
Ech355 3555 5 VALUE = { IF ((ABS(V(11)))>(ABS(V(384))),V(11),V(10)) }
R355 3555 5 1G
R31 337 10 0.001
S331 336 341 3341 5 VON
Ech331 3341 5 VALUE = { IF (V(3555)<-13,5,0) }
Ech31 341 5 VALUE = { IF (V(3555)<-13,0.142857142857143*(V(3555)--13)+15,0) }
S332 336 346 3346 5 VON
Ech332 3346 5 VALUE = { IF ((V(3555)>=-13) & (V(3555)<=14),5,0) }
Ech32 346 5 VALUE = { IF ((V(3555)>=-13) & (V(3555)<=14),((15-10)/((-13-0.855509526361275)*(-13-0.855509526361275)))*(V(3555)-0.855509526361275)*(V(3555)-0.855509526361275) + 10,0) }
S333 336 344 3344 5 VON
Ech333 3344 5 VALUE = { IF (V(3555)>14,5,0) }
Ech33 344 5 VALUE = { IF (V(3555)>14,-0.2*(V(3555)-14)+14.5,0) }
RIN3	336 5	1G
EOUT3 337 381	POLY(2) (336,5) (380,5) 0 0 0 0 0.999/1000
FCOPY3	5 380 VSENSE3 1
RSENSOR3 380 5	1K
VSENSE3 381 384	0
*
* TON/ TOFF/ BBM
S31 382 384 340 5 VON
S32 343 338 343 5 VEN
Ech34 343 5 VALUE = { IF(V(9)<=2.4 & V(187)>=4.4, 5 , 0.8 ) }
eV3 340 5 338 5 1
C36 338 5 1e-012
*
* VOLTAGE SUPPLY REQUIREMENT
S33 11 382 385 5 VON
S34 342 385 342 5 VON
Ech35 342 5 VALUE = { IF((V(4)<=-0.5 & V(4)>=-16.5) & (V(13)<=16.5 & V(13)>=14.5), 5 , 0.01 ) }
S35 339 385 339 5 VON
Ech36 339 5 VALUE = { IF((V(4)>=-0.5 & (V(13)<=13.2 & V(13)>=11.8)), 5 , 0.01 ) }

** SWITCH 4 **
*
* ESD PROTECTION DIODES
D41 4 15 DCLAMP
D42 15 13 DCLAMP
D43 4 14 DCLAMP
D44 14 13 DCLAMP
*
* OFF ISOLATION
C41 14 15 1.25E-012
*
* CHARGE INJECTION
C42 15 440 14E-012
C43 14 440 14E-012
*
* CD/CS OFF AND BANDWIDTH
C44 14 5 9E-012
C45 15 5 9E-012
*
* ON RESISTANCE
Ech455 4555 5 VALUE = { IF ((ABS(V(14)))>(ABS(V(484))),V(14),V(15)) }
R455 4555 5 1G
R41 437 15 0.001
S441 436 441 4441 5 VON
Ech441 4441 5 VALUE = { IF (V(4555)<-13,5,0) }
Ech41 441 5 VALUE = { IF (V(4555)<-13,0.142857142857143*(V(4555)--13)+15,0) }
S442 436 446 4446 5 VON
Ech442 4446 5 VALUE = { IF ((V(4555)>=-13) & (V(4555)<=14),5,0) }
Ech42 446 5 VALUE = { IF ((V(4555)>=-13) & (V(4555)<=14),((15-10)/((-13-0.855509526361275)*(-13-0.855509526361275)))*(V(4555)-0.855509526361275)*(V(4555)-0.855509526361275) + 10,0) }
S443 436 444 4444 5 VON
Ech443 4444 5 VALUE = { IF (V(4555)>14,5,0) }
Ech43 444 5 VALUE = { IF (V(4555)>14,-0.2*(V(4555)-14)+14.5,0) }
RIN4	436 5	1G
EOUT4 437 481	POLY(2) (436,5) (480,5) 0 0 0 0 0.999/1000
FCOPY4	5 480 VSENSE4 1
RSENSOR4 480 5	1K
VSENSE4 481 484	0
*
* TON/ TOFF/ BBM
S41 482 484 440 5 VON
S42 443 438 443 5 VEN
Ech44 443 5 VALUE = { IF(V(16)<=2.4 & V(187)>=4.4, 5 , 0.8 ) }
eV4 440 5 438 5 1
C46 438 5 1e-012
*
* VOLTAGE SUPPLY REQUIREMENT
S43 14 482 485 5 VON
S44 442 485 442 5 VON
Ech45 442 5 VALUE = { IF((V(4)<=-0.5 & V(4)>=-16.5) & (V(13)<=16.5 & V(13)>=14.5), 5 , 0.01 ) }
S45 439 485 439 5 VON
Ech46 439 5 VALUE = { IF((V(4)>=-0.5 & (V(13)<=13.2 & V(13)>=11.8)), 5 , 0.01 ) }

.ENDS ADG411
